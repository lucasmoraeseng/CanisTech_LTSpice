fuse
.OPTIONS LIMPTS=5000 RELTOL=.01
* For Parameter Sweep Replace 800 (in V1) with VIN
* and IB=1 with IB=CURRENT
* OPT CURRENT=1 TO 10 STEP=1
* OPT VIN=200 TO 40000 STEP=200
*SPICE_NET
.TRAN .001 2
*INCLUDE FUSE.LIB
*INCLUDE DEVICE.LIB
*INCLUDE THERMAL.LIB
*ALIAS  I(V1)=ILOAD
*ALIAS  V(59)=TEMP
*ALIAS  V(2)=VBASE
*ALIAS  V(10)=VCTRL
.PRINT TRAN  I(V1) V(59)  V(2)  V(10)
X2 57 0 10 LSWITCH2  {RES=1U}
R1 1 46 200
V1 1 0 PULSE 0 800
X1 57 46 59 FILAMENT  {IB=1 TB=xxx KS=xxx }
E1 2 0 59 0 -1200 1
R3 7 9 10K
V2 7 0 1
Q1 10 3 0 NPN OFF
.MODEL NPN NPN(BR=100 CJC=10PF)
R4 2 3 100MEG
R2 7 10 1MEG
Q13 3 10 9 PNP OFF
.MODEL PNP PNP(BR=100 CJC=10PF)
.END
