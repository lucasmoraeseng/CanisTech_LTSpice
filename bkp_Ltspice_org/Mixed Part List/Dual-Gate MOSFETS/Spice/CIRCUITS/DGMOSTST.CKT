DGMOSTST
**********
.OPTIONS LIMPTS=2000 RELTOL=.001
.OP
*INCLUDE DGMOS.LIB
.SUBCKT MN201 1      2     3     4
*Connections  Drain  Gate2 Gate1 Source
*Dual Gate Mosfet
MD1 5 3 4 4 MN201-1
MD2 1 2 5 4 MN201-2 W=35U
.MODEL MN201-1 NMOS (LEVEL=1 VTO=-1.45 KP=11.8M GAMMA=3.26U
+ PHI=.75 LAMBDA=30M RD=1M RS=20.8 IS=25F PB=.8 MJ=.46
+ CBD=6.64P CBS=7.97P CGSO=168P CGDO=140P CGBO=32.6N)
.MODEL MN201-2 NMOS (LEVEL=1 VTO=-1.00 KP=12.5M GAMMA=27.26U
+ PHI=.75 LAMBDA=37M RD=15.3 RS=1M IS=30F PB=.8 MJ=.46
+ CBD=6.64P CBS=7.97P CGSO=168P CGDO=140P CGBO=32.6N)
* Motorola
* N-Channel Depletion DG-MOSFET
.ENDS
*MAKE SURE TO USE THE CORRECT .LIB FILENAME
*dEFINE DUT=MN201
*REPLACE MN201= WITH MN201=YOUR MODEL NAME
*FOR P CHANNEL FETS FLIP VGS, VDS, AND V2
.DC VDS 0 20 .1 VGS1 -1 1 .5
*.DC VGS1 -1.5 1 .1 VGS2 0 4 1
*FOR ID VS. VGS CURVE, USE .DC VGS ONLY, PLOT I(V3) VS. VGS
*SPICE_NET
*ALIAS  I(V3)=ID
.PRINT DC  I(V3)
VDS 4 0 15
*SET VDS RANGE IN THE .DC STATEMENT
VGS2 1 0 4
*SET VGS RANGE IN THE .DC STATEMENT
X3 5 1 3 0 MN201
V6 3 2
VGS1 2 0
V3 4 5
.END
