DG4
*SPICE_NET
*INCLUDE DGMOS.LIB
.SUBCKT MN201 1      2     3     4
*Connections  Drain  Gate2 Gate1 Source
*Dual Gate Mosfet
MD1 5 3 4 4 MN201-1
MD2 1 2 5 4 MN201-2 W=35U
.MODEL MN201-1 NMOS (LEVEL=1 VTO=-1.45 KP=11.8M GAMMA=3.26U
+ PHI=.75 LAMBDA=30M RD=1M RS=20.8 IS=25F PB=.8 MJ=.46
+ CBD=6.64P CBS=7.97P CGSO=168P CGDO=140P CGBO=32.6N)
.MODEL MN201-2 NMOS (LEVEL=1 VTO=-1.00 KP=12.5M GAMMA=27.26U
+ PHI=.75 LAMBDA=37M RD=15.3 RS=1M IS=30F PB=.8 MJ=.46
+ CBD=6.64P CBS=7.97P CGSO=168P CGDO=140P CGBO=32.6N)
* Motorola
* N-Channel Depletion DG-MOSFET
.ENDS
.TRAN .1N 1000N 0
.OPTIONS LIMPTS=22000 ITL5=0
*INCLUDE DEVICE.LIB
.MODEL DN4148 D(RS=.8 CJO=4PF IS=7E-09 N=2 VJ=.6V
+ TT=6E-09 M=.45 BV=100V)
*ALIAS  V(7)=TANK
*ALIAS  V(2)=DRAIN
*ALIAS  V(5)=VG2
*ALIAS  V(8)=VG1
.PRINT TRAN  V(7)  V(2)  V(5)  V(8)
.PRINT TRAN  V(10)
R1 1 4 270
R2 3 2 100
C1 1 4 .05U
C2 2 0 .05U
R3 3 5 180K
V1 3 0 PULSE 0 18
R4 5 10 20K
R5 5 5 50K
R6 5 0 50K
R7 8 0 47K
D1 8 0 DN4148
C3 7 0 10P
L1 7 4 .2024U
L2 4 0 .0506U
C4 7 8 47P
C5 5 0 .01U
V2 10 0 0
X1 2 5 8 1 MN201
.END
