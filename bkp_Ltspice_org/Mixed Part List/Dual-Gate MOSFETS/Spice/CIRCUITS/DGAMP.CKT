DG3
*SPICE_NET
*INCLUDE DGMOS.LIB
.SUBCKT MN201 1      2     3     4
*Connections  Drain  Gate2 Gate1 Source
*Dual Gate Mosfet
MD1 5 3 4 4 MN201-1
MD2 1 2 5 4 MN201-2 W=35U
.MODEL MN201-1 NMOS (LEVEL=1 VTO=-1.45 KP=11.8M GAMMA=3.26U
+ PHI=.75 LAMBDA=30M RD=1M RS=20.8 IS=25F PB=.8 MJ=.46
+ CBD=6.64P CBS=7.97P CGSO=168P CGDO=140P CGBO=32.6N)
.MODEL MN201-2 NMOS (LEVEL=1 VTO=-1.00 KP=12.5M GAMMA=27.26U
+ PHI=.75 LAMBDA=37M RD=15.3 RS=1M IS=30F PB=.8 MJ=.46
+ CBD=6.64P CBS=7.97P CGSO=168P CGDO=140P CGBO=32.6N)
* Motorola
* N-Channel Depletion DG-MOSFET
.ENDS
.TRAN .05N 20N
.AC DEC 10 100K 1000MEG
.OPTIONS RELTOL=.01 LIMPTS=2000
*ALIAS  V(11)=OUTPUT
*ALIAS  V(1)=INPUT
*ALIAS  V(2)=VIN
.PRINT AC  V(11)  VP(11)  V(1)  VP(1)
.PRINT AC  V(2)  VP(2)
.PRINT TRAN  V(11)  V(1)  V(2)
L1 2 3 1M
C1 12 2 5P
C2 3 0 500P
R1 0 3 300K
R2 3 7 360K
R3 7 6 820K
C3 6 0 500PF
L2 6 9 1M
C4 2 0 4P
X1 9 7 2 8 MN201
C5 7 0 500P
R5 8 0 270
C6 8 0 500P
C7 9 0 5P
R6 11 0 50
C8 9 11 5P
R7 1 12 50
V2 6 0 8
V1 1 0 SIN 0 10 200MEG AC 1
.END
