* m_qtsra_qss01
***************************************************************************
*                            COPYRIGHT, SAMTEC                            *
*                     ALL INTERNATIONAL RIGHTS RESERVED                   *
***************************************************************************
*!!!!!!!!!!!!!!!!!!!!!!!!!!!!!!!!!!!!!!!!!!!!!!!!!!!!!!!!!!!!!!!!!!!!!!!!!!
*! Samtec makes no warranty or guarantee as to the suitability of its     !
*! products or models for any specific application. Models were developed !
*! using nominal values for physical dimensions and material properties,  !
*! and specific grounding and boundary conditions.                        !
*!                                                                        !
*! Actual in-circuit performance can vary significantly from simulated    !
*! results.  All parameters should be validated by the customer's own     !
*! technical experts.  By downloading a model, the user agrees to absolve !
*! Samtec from all liability related to the use or application of the     !
*! model or product.                                                      !
*!                                                                        !
*! Samtec reserves the right to change a model at any time without        !
*! further notice.                                                        !
*!!!!!!!!!!!!!!!!!!!!!!!!!!!!!!!!!!!!!!!!!!!!!!!!!!!!!!!!!!!!!!!!!!!!!!!!!!
*
* Connector: QTS-xxx-01-x-D-RA__QSS-xxx-01-x-D-A-xx
* Rev Date : 02/13/2003
* Status   : DEVELOPMENTAL
* Structure: 2 row x 8 column
* Rating   : 50 ps Tr/Tf (10%-90%) or slower
*
***************************************************************************
**** README ************ CONNECTOR MODEL STRUCTURE ************ README ****
***************************************************************************
*
* MODEL BOUNDARIES:  QTS connector SMT Tail to QSS connector SMT Tail
* (NO TERMINATIONS, DRIVING SOURCES, OR PARASITIC CAPACITANCES ARE INCLUDED)
*
* NODE SEQUENCE:  **Important Note** - This model is not "homogenous";
*                 for accurate results, side A represents the QTS connector side,
*                 side B represents the QSS connector side
*
*                                               6xxx (inner/short row)
*                        1xxx                  10xxx (outer/long row)
* QTS connector (side a)-- |-- Connector Model --|-- QSS connector (side b)
*
*
* CONTACT ID:
* PCB Footprint View (QTS Connector)
* column******************08****07****06****05****04****03****02****01
* row 02.(inner/short).. n208  n207  n206  n205  n204  n203  n202  n201
* row GND............... -------------------- n301 -------------------
* row 01 (outer/long)... n108  n107  n106  n105  n104  n103  n102  n101
*
* NOTE:  Model node n101 maps to connector pin 01
*        Model node n201 maps to connector pin 02
*
* PCB Footprint View (QSS Connector)
* column******************01****02****03****04****05****06****07****08
* row 02.(inner/short).. n201  n202  n203  n204  n205  n206  n207  n208
* row GND............... -------------------- n301 -------------------
* row 01 (outer/long)... n101  n102  n103  n104  n105  n106  n107  n108
*
* NOTE:  Model node n101 maps to connector pin 01
*        Model node n201 maps to connector pin 02
*
***************************** CONNECTOR MODEL *****************************
* QTS-RA/QSS, 2 ROWS
.SUBCKT QTSRAQSS
* PLUG SIDE (QTS-RA)
* OUTER ROW
+ 1101 1102 1103 1104 1105 1106 1107 1108
* GROUND
+ 1301
* INNER ROW
+ 1201 1202 1203 1204 1205 1206 1207 1208
* RECEPTACLE SIDE (QSS)
* OUTER ROW
+ 10101 10102 10103 10104 10105 10106 10107 10108
* GROUND
+ 8301
* INNER ROW
+ 6201 6202 6203 6204 6205 6206 6207 6208
* Lqtsraqssa
LS1101 1101 2101 1.52E-10
LS1102 1102 2102 1.03E-10
LS1103 1103 2103 1.03E-10
LS1104 1104 2104 1.03E-10
LS1105 1105 2105 1.03E-10
LS1106 1106 2106 1.03E-10
LS1107 1107 2107 1.03E-10
LS1108 1108 2108 1.50E-10
LS1201 1201 2201 1.93E-10
LS1202 1202 2202 1.38E-10
LS1203 1203 2203 1.38E-10
LS1204 1204 2204 1.38E-10
LS1205 1205 2205 1.38E-10
LS1206 1206 2206 1.38E-10
LS1207 1207 2207 1.38E-10
LS1208 1208 2208 1.89E-10
LS1301 1301 2301 2.10E-12
*
* Lqtsraqssa1
LS2101 2101 3101 5.54E-10
LS2102 2102 3102 3.74E-10
LS2103 2103 3103 3.74E-10
LS2104 2104 3104 3.73E-10
LS2105 2105 3105 3.73E-10
LS2106 2106 3106 3.73E-10
LS2107 2107 3107 3.74E-10
LS2108 2108 3108 5.44E-10
LS2301 2301 3301 7.62E-12
* Lqtsraqssa2
LS3101 3101 4101 3.65E-10
LS3102 3102 4102 2.34E-10
LS3103 3103 4103 2.33E-10
LS3104 3104 4104 2.33E-10
LS3105 3105 4105 2.33E-10
LS3106 3106 4106 2.33E-10
LS3107 3107 4107 2.34E-10
LS3108 3108 4108 3.65E-10
* Lqtsraqssb
LS4101 4101 5101 5.24E-10
LS4102 4102 5102 3.26E-10
LS4103 4103 5103 3.25E-10
LS4104 4104 5104 3.25E-10
LS4105 4105 5105 3.25E-10
LS4106 4106 5106 3.25E-10
LS4107 4107 5107 3.26E-10
LS4108 4108 5108 5.18E-10
* Lqtsraqssc
LS5101 5101 6101 5.30E-10
LS5102 5102 6102 3.65E-10
LS5103 5103 6103 3.65E-10
LS5104 5104 6104 3.65E-10
LS5105 5105 6105 3.65E-10
LS5106 5106 6106 3.65E-10
LS5107 5107 6107 3.65E-10
LS5108 5108 6108 5.31E-10
LS3301 3301 4301 6.30E-12
* Lqtsraqssd
LS6101 6101 7101 1.26E-09
LS6102 6102 7102 9.05E-10
LS6103 6103 7103 9.03E-10
LS6104 6104 7104 9.02E-10
LS6105 6105 7105 9.02E-10
LS6106 6106 7106 9.03E-10
LS6107 6107 7107 9.05E-10
LS6108 6108 7108 1.24E-09
LS2201 2201 3201 1.26E-09
LS2202 2202 3202 9.05E-10
LS2203 2203 3203 9.03E-10
LS2204 2204 3204 9.02E-10
LS2205 2205 3205 9.02E-10
LS2206 2206 3206 9.03E-10
LS2207 2207 3207 9.05E-10
LS2208 2208 3208 1.24E-09
LS4301 4301 5301 1.36E-11
* Lqtsraqsse
LS7101 7101 8101 2.34E-10
LS7102 7102 8102 1.62E-10
LS7103 7103 8103 1.62E-10
LS7104 7104 8104 1.62E-10
LS7105 7105 8105 1.62E-10
LS7106 7106 8106 1.62E-10
LS7107 7107 8107 1.62E-10
LS7108 7108 8108 2.20E-10
LS3201 3201 4201 2.30E-10
LS3202 3202 4202 1.60E-10
LS3203 3203 4203 1.60E-10
LS3204 3204 4204 1.60E-10
LS3205 3205 4205 1.60E-10
LS3206 3206 4206 1.61E-10
LS3207 3207 4207 1.62E-10
LS3208 3208 4208 2.28E-10
LS5301 5301 6301 3.68E-12
* Lqtsraqsse1
LS8101 8101 9101 3.75E-10
LS8102 8102 9102 3.34E-10
LS8103 8103 9103 3.34E-10
LS8104 8104 9104 3.34E-10
LS8105 8105 9105 3.34E-10
LS8106 8106 9106 3.34E-10
LS8107 8107 9107 3.32E-10
LS8108 8108 9108 3.55E-10
LS4201 4201 5201 3.66E-10
LS4202 4202 5202 3.26E-10
LS4203 4203 5203 3.26E-10
LS4204 4204 5204 3.26E-10
LS4205 4205 5205 3.29E-10
LS4206 4206 5206 3.34E-10
LS4207 4207 5207 3.35E-10
LS4208 4208 5208 3.72E-10
LS6301 6301 7301 3.06E-12
* Lqtsraqssf
LS9101 9101 10101 4.55E-10
LS9102 9102 10102 3.64E-10
LS9103 9103 10103 3.61E-10
LS9104 9104 10104 3.61E-10
LS9105 9105 10105 3.62E-10
LS9106 9106 10106 3.63E-10
LS9107 9107 10107 3.61E-10
LS9108 9108 10108 4.12E-10
LS5201 5201 6201 4.36E-10
LS5202 5202 6202 3.55E-10
LS5203 5203 6203 3.53E-10
LS5204 5204 6204 3.53E-10
LS5205 5205 6205 3.56E-10
LS5206 5206 6206 3.62E-10
LS5207 5207 6207 3.65E-10
LS5208 5208 6208 4.39E-10
LS7301 7301 8301 2.86E-10
* Cqtsraqssa
C210101 2101 2102 2.37E-14
C210102 2101 2103 2.03E-15
C210116 2101 2301 8.36E-15
*
C210201 2102 2103 2.23E-14
C210202 2102 2104 1.50E-15
C210215 2102 2301 5.60E-15
*
C210301 2103 2104 2.23E-14
C210302 2103 2105 1.48E-15
C210314 2103 2301 5.56E-15
*
C210401 2104 2105 2.23E-14
C210402 2104 2106 1.47E-15
C210413 2104 2301 5.57E-15
*
C210501 2105 2106 2.23E-14
C210502 2105 2107 1.49E-15
C210512 2105 2301 5.62E-15
*
C210601 2106 2107 2.23E-14
C210602 2106 2108 1.92E-15
C210611 2106 2301 5.75E-15
*
C210701 2107 2108 2.35E-14
C210710 2107 2301 6.14E-15
*
C210809 2108 2301 1.11E-14
*
C220101 2201 2202 2.58E-14
C220102 2201 2203 2.71E-15
*
C220201 2202 2203 2.39E-14
C220202 2202 2204 1.95E-15
*
C220301 2203 2204 2.38E-14
C220302 2203 2205 1.91E-15
*
C220401 2204 2205 2.38E-14
C220402 2204 2206 1.93E-15
*
C220501 2205 2206 2.37E-14
C220502 2205 2207 2.10E-15
*
C220601 2206 2207 2.39E-14
C220602 2206 2208 2.81E-15
*
C220701 2207 2208 2.55E-14
* Cqtsraqssa1
C310101 3101 3102 8.96E-14
C310102 3101 3103 7.90E-15
C310103 3101 3104 2.98E-15
C310104 3101 3105 1.46E-15
C310107 3101 3108 1.31E-15
C310108 3101 3301 3.40E-14
*
C310201 3102 3103 8.41E-14
C310202 3102 3104 5.83E-15
C310203 3102 3105 1.98E-15
C310207 3102 3301 2.27E-14
*
C310301 3103 3104 8.39E-14
C310302 3103 3105 5.73E-15
C310303 3103 3106 1.93E-15
C310306 3103 3301 2.25E-14
*
C310401 3104 3105 8.39E-14
C310402 3104 3106 5.72E-15
C310403 3104 3107 1.97E-15
C310404 3104 3108 1.35E-15
C310405 3104 3301 2.25E-14
*
C310501 3105 3106 8.39E-14
C310502 3105 3107 5.80E-15
C310503 3105 3108 2.76E-15
C310504 3105 3301 2.27E-14
*
C310601 3106 3107 8.41E-14
C310602 3106 3108 7.45E-15
C310603 3106 3301 2.32E-14
*
C310701 3107 3108 8.85E-14
C310702 3107 3301 2.49E-14
*
C310801 3108 3301 4.45E-14
* Cqtsraqssa2
C410101 4101 4102 5.93E-14
C410102 4101 4103 8.07E-15
C410103 4101 4104 4.39E-15
C410104 4101 4105 2.97E-15
C410105 4101 4106 2.33E-15
C410106 4101 4107 2.13E-15
C410107 4101 4108 3.84E-15
*
C410201 4102 4103 5.39E-14
C410202 4102 4104 5.28E-15
C410203 4102 4105 2.60E-15
C410204 4102 4106 1.70E-15
C410205 4102 4107 1.36E-15
C410206 4102 4108 2.17E-15
*
C410301 4103 4104 5.35E-14
C410302 4103 4105 5.05E-15
C410303 4103 4106 2.49E-15
C410304 4103 4107 1.71E-15
C410305 4103 4108 2.39E-15
*
C410401 4104 4105 5.34E-14
C410402 4104 4106 5.05E-15
C410403 4104 4107 2.61E-15
C410404 4104 4108 3.05E-15
*
C410501 4105 4106 5.35E-14
C410502 4105 4107 5.28E-15
C410503 4105 4108 4.46E-15
*
C410601 4106 4107 5.39E-14
C410602 4106 4108 8.14E-15
*
C410701 4107 4108 5.93E-14
* Cqtsraqssb
C510101 5101 5102 1.93E-13
C510102 5101 5103 1.20E-14
C510103 5101 5104 4.66E-15
C510104 5101 5105 2.37E-15
C510105 5101 5106 1.47E-15
C510107 5101 5108 2.51E-15
*
C510201 5102 5103 1.85E-13
C510202 5102 5104 8.51E-15
C510203 5102 5105 2.94E-15
C510204 5102 5106 1.33E-15
*
C510301 5103 5104 1.84E-13
C510302 5103 5105 8.37E-15
C510303 5103 5106 2.87E-15
C510304 5103 5107 1.32E-15
C510305 5103 5108 1.39E-15
*
C510401 5104 5105 1.84E-13
C510402 5104 5106 8.36E-15
C510403 5104 5107 2.92E-15
C510404 5104 5108 2.23E-15
*
C510501 5105 5106 1.84E-13
C510502 5105 5107 8.47E-15
C510503 5105 5108 4.41E-15
*
C510601 5106 5107 1.84E-13
C510602 5106 5108 1.14E-14
*
C510701 5107 5108 1.92E-13
* Cqtsraqssc
C610101 6101 6102 8.75E-14
C610102 6101 6103 7.25E-15
C610103 6101 6104 2.67E-15
C610104 6101 6105 1.30E-15
C610108 6101 4301 3.57E-14
*
C610201 6102 6103 8.25E-14
C610202 6102 6104 5.46E-15
C610203 6102 6105 1.81E-15
C610207 6102 4301 2.16E-14
*
C610301 6103 6104 8.24E-14
C610302 6103 6105 5.38E-15
C610303 6103 6106 1.77E-15
C610306 6103 4301 2.07E-14
*
C610401 6104 6105 8.23E-14
C610402 6104 6106 5.38E-15
C610403 6104 6107 1.80E-15
C610404 6104 6108 1.24E-15
C610405 6104 4301 2.05E-14
*
C610501 6105 6106 8.24E-14
C610502 6105 6107 5.45E-15
C610504 6105 4301 2.06E-14
*
C610601 6106 6107 8.25E-14
C610602 6106 6108 6.99E-15
C610603 6106 4301 2.10E-14
*
C610701 6107 6108 8.67E-14
C610702 6107 4301 2.25E-14
*
C610801 6108 4301 4.09E-14
* Cqtsraqssd
C710100 7101 7102 7.47E-14
C710101 7101 7103 7.36E-15
C710102 7101 7104 3.09E-15
C710103 7101 7105 1.78E-15
C710104 7101 7106 1.25E-15
C710106 7101 7108 1.96E-15
C710107 7101 3201 3.18E-15
C710115 7101 5301 1.97E-14
*
C710201 7102 7103 7.01E-14
C710202 7102 7104 5.43E-15
C710203 7102 7105 2.01E-15
C710215 7102 5301 1.30E-15
*
C710301 7103 7104 6.99E-14
C710302 7103 7105 5.32E-15
C710303 7103 7106 1.94E-15
C710314 7103 5301 1.25E-14
*
C710401 7104 7105 6.99E-14
C710402 7104 7106 5.32E-15
C710403 7104 7107 1.99E-15
C710404 7104 7108 1.70E-15
C710413 7104 5301 1.26E-14
*
C710501 7105 7106 6.99E-14
C710502 7105 7107 5.41E-15
C710503 7105 7108 2.98E-15
C710512 7105 5301 1.27E-14
*
C710601 7106 7107 7.01E-14
C710602 7106 7108 7.17E-15
C710611 7106 5301 1.30E-14
*
C710701 7107 7108 7.43E-14
C710710 7107 5301 1.40E-14
*
C710801 7108 3201 9.90E-16
C710809 7108 5301 2.60E-14
*
C320101 3201 3202 7.47E-14
C320102 3201 3203 7.36E-15
C320103 3201 3204 3.09E-15
C320104 3201 3205 1.78E-15
C320105 3201 3206 1.25E-15
C320107 3201 3208 1.96E-15
C320108 3201 5301 1.98E-14
*
C320201 3202 3203 7.01E-14
C320202 3202 3204 5.43E-15
C320203 3202 3205 2.01E-15
C320207 3202 5301 1.27E-14
*
C320301 3203 3204 6.99E-14
C320302 3203 3205 5.32E-15
C320303 3203 3206 1.94E-15
C320306 3203 5301 1.26E-14
*
C320401 3204 3205 6.98E-14
C320402 3204 3206 5.32E-15
C320403 3204 3207 1.99E-15
C320404 3204 3208 1.70E-15
C320405 3204 5301 1.26E-14
*
C320501 3205 3206 6.99E-14
C320502 3205 3207 5.41E-15
C320503 3205 3208 2.98E-15
C320504 3205 5301 1.27E-14
*
C320601 3206 3207 7.01E-14
C320602 3206 3208 7.17E-15
C320603 3206 5301 1.30E-14
*
C320701 3207 3208 7.43E-14
C320702 3207 5301 1.40E-14
*
C320801 3208 5301 2.61E-14
* Cqtsraqsse
C810100 8101 8102 6.62E-14
C810101 8101 8103 6.45E-15
C810102 8101 8104 2.16E-15
C810107 8101 4201 3.58E-15
C810115 8101 6301 1.42E-14
*
C810201 8102 8103 6.19E-14
C810202 8102 8104 4.97E-15
C810203 8102 8105 1.41E-15
C810215 8102 6301 8.92E-15
*
C810301 8103 8104 6.17E-14
C810302 8103 8105 4.89E-15
C810303 8103 8106 1.38E-15
C810314 8103 6301 8.59E-15
*
C810401 8104 8105 6.17E-14
C810402 8104 8106 4.89E-15
C810403 8104 8107 1.41E-15
C810413 8104 6301 8.55E-15
*
C810501 8105 8106 6.17E-14
C810502 8105 8107 4.94E-15
C810503 8105 8108 2.00E-15
C810512 8105 6301 8.69E-15
*
C810601 8106 8107 6.18E-14
C810602 8106 8108 6.04E-15
C810611 8106 6301 9.28E-15
*
C810701 8107 8108 6.49E-14
C810710 8107 6301 1.16E-14
*
C810809 8108 6301 2.59E-14
*
C420101 4201 4202 6.50E-14
C420102 4201 4203 5.78E-15
C420103 4201 4204 1.94E-15
C420108 4201 6301 1.86E-14
*
C420201 4202 4203 6.08E-14
C420202 4202 4204 4.40E-15
C420203 4202 4205 1.24E-15
* 5.20E-16
C420207 4202 6301 1.43E-14
*
C420301 4203 4204 6.06E-14
C420302 4203 4205 4.35E-15
C420303 4203 4206 1.23E-15
* 2.25E-16
C420306 4203 6301 1.42E-14
*
C420401 4204 4205 6.08E-14
C420402 4204 4206 4.51E-15
C420403 4204 4207 1.33E-15
* 1.68E-16
C420405 4204 6301 1.38E-14
*
C420501 4205 4206 6.15E-14
C420502 4205 4207 4.85E-15
C420503 4205 4208 2.08E-15
* 1.66E-16
C420504 4205 6301 1.21E-14
*
C420601 4206 4207 6.20E-14
C420602 4206 4208 6.36E-15
* 2.07E-16
C420603 4206 6301 1.00E-14
*
C420701 4207 4208 6.63E-14
* 3.63E-16
C420702 4207 6301 9.85E-15
*
C420801 4208 6301 1.82E-14
* Cqtsraqsse1
C910100 9101 9102 3.20E-15
C910200 9102 9103 2.56E-15
C910300 9103 9104 2.54E-15
C910400 9104 9105 2.54E-15
C910500 9105 9106 2.54E-15
C910600 9106 9107 2.55E-15
C910700 9107 9108 2.90E-15
C910717 9107 7301 1.71E-15
C910800 9108 7301 6.86E-15
C520100 5201 5202 3.01E-15
C520108 5201 7301 4.23E-15
*
C520200 5202 5203 2.46E-15
C520207 5202 7301 1.48E-15
*
C520300 5203 5204 2.45E-15
C520306 5203 7301 1.25E-15
*
C520400 5204 5205 2.46E-15
*
C520500 5205 5206 2.50E-15
*
C520600 5206 5207 2.55E-15
*
C520700 5207 5208 3.05E-15
C520702 5207 7301 1.35E-15
* Cqtsraqssf
C1010100 10101 10102 1.99E-14
C1010101 10101 10103 4.23E-15
C1010102 10101 10104 1.86E-15
C1010107 10101 6201 3.23E-15
C1010116 10101 8301 7.29E-15
*
C1010201 10102 10103 1.78E-14
C1010202 10102 10104 3.28E-15
C1010203 10102 10105 1.32E-15
C1010216 10102 8301 5.75E-15
*
C1010301 10103 10104 1.76E-14
C1010302 10103 10105 3.15E-15
C1010303 10103 10106 1.24E-15
C1010315 10103 8301 5.58E-15
*
C1010401 10104 10105 1.75E-14
C1010402 10104 10106 3.11E-15
C1010403 10104 10107 1.26E-15
C1010414 10104 8301 5.05E-15
*
C1010501 10105 10106 1.74E-14
C1010502 10105 10107 3.11E-15
C1010503 10105 10108 1.53E-15
C1010513 10105 8301 3.94E-15
*
C1010601 10106 10107 1.72E-14
C1010602 10106 10108 3.42E-15
C1010611 10106 8301 3.72E-15
*
C1010701 10107 10108 1.79E-14
C1010710 10107 8301 7.76E-15
*
C1010809 10108 8301 1.91E-14
*
C620101 6201 6202 1.82E-14
C620102 6201 6203 3.25E-15
C620103 6201 6204 1.42E-15
C620109 6201 8301 1.31E-14
*
C620201 6202 6203 1.63E-14
C620202 6202 6204 2.48E-15
C620208 6202 8301 1.29E-14
*
C620301 6203 6204 1.62E-14
C620302 6203 6205 2.44E-15
C620307 6203 8301 1.31E-14
*
C620401 6204 6205 1.63E-14
C620402 6204 6206 2.61E-15
C620406 6204 8301 1.22E-14
*
C620501 6205 6206 1.68E-14
C620502 6205 6207 3.04E-15
C620503 6205 6208 1.79E-15
C620504 6205 8301 1.24E-15
C620505 6205 8301 8.98E-15
*
C620601 6206 6207 1.75E-14
C620602 6206 6208 4.14E-15
C620603 6206 8301 2.56E-15
C620604 6206 8301 4.71E-15
*
C620701 6207 6208 1.97E-14
C620702 6207 8301 4.58E-15
C620703 6207 8301 2.21E-15
*
C620801 6208 8301 1.03E-14
* Kqtsraqssa
K1101001 LS1101 LS1102 0.4654
K1101002 LS1101 LS1103 0.03976
K1101003 LS1101 LS1104 0.01499
K1101008 LS1101 LS1201 0.01534
K1101016 LS1101 LS1301 0.02879
*
K1102001 LS1102 LS1103 0.3661
K1102002 LS1102 LS1104 0.02458
K1102015 LS1102 LS1301 0.01616
*
K1103001 LS1103 LS1104 0.3645
K1103002 LS1103 LS1105 0.02416
K1103014 LS1103 LS1301 0.01601
*
K1104001 LS1104 LS1105 0.3643
K1104002 LS1104 LS1106 0.02414
K1104013 LS1104 LS1301 0.01606
*
K1105001 LS1105 LS1106 0.3645
K1105002 LS1105 LS1107 0.02447
K1105003 LS1105 LS1108 0.01382
K1105012 LS1105 LS1301 0.0162
*
K1106001 LS1106 LS1107 0.3656
K1106002 LS1106 LS1108 0.03706
K1106011 LS1106 LS1301 0.01656
*
K1107001 LS1107 LS1108 0.4524
K1107010 LS1107 LS1301 0.01772
*
K1108009 LS1108 LS1301 0.03758
*
K1201001 LS1201 LS1202 0.4761
K1201002 LS1201 LS1203 0.04985
K1201003 LS1201 LS1204 0.01873
*
K1202001 LS1202 LS1203 0.3688
K1202002 LS1202 LS1204 0.03012
*
K1203001 LS1203 LS1204 0.3668
K1203002 LS1203 LS1205 0.02942
*
K1204001 LS1204 LS1205 0.3655
K1204002 LS1204 LS1206 0.0297
*
K1205001 LS1205 LS1206 0.3639
K1205002 LS1205 LS1207 0.03233
K1205003 LS1205 LS1208 0.02056
*
K1206001 LS1206 LS1207 0.3662
K1206002 LS1206 LS1208 0.05136
*
K1207001 LS1207 LS1208 0.4654
* Kqtsraqssa1
K2101001 LS2101 LS2102 0.4615
K2101002 LS2101 LS2103 0.04061
K2101003 LS2101 LS2104 0.01529
K2101008 LS2101 LS2301 0.03135
*
K2102001 LS2102 LS2103 0.3629
K2102002 LS2102 LS2104 0.02514
K2102007 LS2102 LS2301 0.0176
*
K2103001 LS2103 LS2104 0.3613
K2103002 LS2103 LS2105 0.02466
K2103006 LS2103 LS2301 0.01739
*
K2104001 LS2104 LS2105 0.3612
K2104002 LS2104 LS2106 0.02464
K2104005 LS2104 LS2301 0.01743
*
K2105001 LS2105 LS2106 0.3611
K2105002 LS2105 LS2107 0.02498
K2105003 LS2105 LS2108 0.01395
K2105004 LS2105 LS2301 0.01757
*
K2106001 LS2106 LS2107 0.3625
K2106002 LS2106 LS2108 0.03758
K2106003 LS2106 LS2301 0.01797
*
K2107001 LS2107 LS2108 0.4474
K2107002 LS2107 LS2301 0.01924
*
K2108001 LS2108 LS2301 0.04035
* Kqtsraqssa2
K3101001 LS3101 LS3102 0.5212
K3101002 LS3101 LS3103 0.07065
K3101003 LS3101 LS3104 0.03838
K3101004 LS3101 LS3105 0.02603
K3101005 LS3101 LS3106 0.0204
K3101006 LS3101 LS3107 0.01873
K3101007 LS3101 LS3108 0.04149
*
K3102001 LS3102 LS3103 0.3828
K3102002 LS3102 LS3104 0.03744
K3102003 LS3102 LS3105 0.01846
K3102006 LS3102 LS3108 0.01905
*
K3103001 LS3103 LS3104 0.3786
K3103002 LS3103 LS3105 0.03572
K3103003 LS3103 LS3106 0.0176
K3103005 LS3103 LS3108 0.02091
*
K3104001 LS3104 LS3105 0.3777
K3104002 LS3104 LS3106 0.03573
K3104003 LS3104 LS3107 0.01853
K3104004 LS3104 LS3108 0.02663
*
K3105001 LS3105 LS3106 0.3786
K3105002 LS3105 LS3107 0.0375
K3105003 LS3105 LS3108 0.039
*
K3106001 LS3106 LS3107 0.3829
K3106002 LS3106 LS3108 0.07113
*
K3107001 LS3107 LS3108 0.5202
* Kqtsraqssb
K4101001 LS4101 LS4102 0.5118
K4101002 LS4101 LS4103 0.03161
*
K4102001 LS4102 LS4103 0.393
K4102002 LS4102 LS4104 0.01812
*
K4103001 LS4103 LS4104 0.3919
K4103002 LS4103 LS4105 0.0178
*
K4104001 LS4104 LS4105 0.3917
K4104002 LS4104 LS4106 0.01778
*
K4105001 LS4105 LS4106 0.3918
K4105002 LS4105 LS4107 0.01803
*
K4106001 LS4106 LS4107 0.3926
K4106002 LS4106 LS4108 0.02972
*
K4107001 LS4107 LS4108 0.5006
* Kqtsraqssc
K5101001 LS5101 LS5102 0.4646
K5101002 LS5101 LS5103 0.03847
K5101003 LS5101 LS5104 0.01414
K5101009 LS5101 LS4101 0.03135
*
K5102001 LS5102 LS5103 0.3672
K5102002 LS5102 LS5104 0.0243
K5102008 LS5102 LS4101 0.01592
*
K5103001 LS5103 LS5104 0.3659
K5103002 LS5103 LS5105 0.02391
K5103007 LS5103 LS4101 0.01525
*
K5104001 LS5104 LS5105 0.3658
K5104002 LS5104 LS5106 0.02391
K5104006 LS5104 LS4101 0.0151
*
K5105001 LS5105 LS5106 0.3659
K5105002 LS5105 LS5107 0.02423
K5105003 LS5105 LS5108 0.01337
K5105005 LS5105 LS4101 0.01514
*
K5106001 LS5106 LS5107 0.3669
K5106002 LS5106 LS5108 0.03663
K5106004 LS5106 LS4101 0.01545
*
K5107001 LS5107 LS5108 0.4547
K5107003 LS5107 LS4101 0.01653
*
K5108002 LS5108 LS4101 0.03543
* Kqtsraqssd
K6101001 LS6101 LS6102 0.464
K6101002 LS6101 LS6103 0.04565
K6101003 LS6101 LS6104 0.01917
K6101007 LS6101 LS6108 0.01423
K6101008 LS6101 LS2201 0.02331
K6101016 LS6101 LS4301 0.01497
*
K6102001 LS6102 LS6103 0.3684
K6102002 LS6102 LS6104 0.02854
*
K6103001 LS6103 LS6104 0.3667
K6103002 LS6103 LS6105 0.02791
*
K6104001 LS6104 LS6105 0.3664
K6104002 LS6104 LS6106 0.02789
*
K6105001 LS6105 LS6106 0.3666
K6105002 LS6105 LS6107 0.02842
K6105003 LS6105 LS6108 0.01832
*
K6106001 LS6106 LS6107 0.3681
K6106002 LS6106 LS6108 0.04413
*
K6107001 LS6107 LS6108 0.4581
*
K6108009 LS6108 LS4301 0.01964
*
K2201001 LS2201 LS2202 0.464
K2201002 LS2201 LS2203 0.04564
K2201003 LS2201 LS2204 0.01917
K2201007 LS2201 LS2208 0.01422
*
K2202001 LS2202 LS2203 0.3684
K2202002 LS2202 LS2204 0.02855
*
K2203001 LS2203 LS2204 0.3667
K2203002 LS2203 LS2205 0.02791
*
K2204001 LS2204 LS2205 0.3664
K2204002 LS2204 LS2206 0.02789
*
K2205001 LS2205 LS2206 0.3666
K2205002 LS2205 LS2207 0.02842
K2205003 LS2205 LS2208 0.01832
*
K2206001 LS2206 LS2207 0.3681
K2206002 LS2206 LS2208 0.04413
*
K2207001 LS2207 LS2208 0.4581
* Kqtsraqsse
K7101001 LS7101 LS7102 0.4886
K7101002 LS7101 LS7103 0.04748
K7101003 LS7101 LS7104 0.01587
K7101008 LS7101 LS3201 0.03146
K7101016 LS7101 LS5301 0.02265
*
K7102001 LS7102 LS7103 0.3797
K7102002 LS7102 LS7104 0.03046
*
K7103001 LS7103 LS7104 0.3781
K7103002 LS7103 LS7105 0.02997
*
K7104001 LS7104 LS7105 0.378
K7104002 LS7104 LS7106 0.02996
*
K7105001 LS7105 LS7106 0.3781
K7105002 LS7105 LS7107 0.03025
K7105003 LS7105 LS7108 0.01453
*
K7106001 LS7106 LS7107 0.3785
K7106002 LS7106 LS7108 0.0438
*
K7107001 LS7107 LS7108 0.4709
K7107010 LS7107 LS5301 0.01542
*
K7108009 LS7108 LS5301 0.04076
*
K3201001 LS3201 LS3202 0.4716
K3201002 LS3201 LS3203 0.04191
K3201003 LS3201 LS3204 0.01406
*
K3202001 LS3202 LS3203 0.3678
K3202002 LS3202 LS3204 0.0266
*
K3203001 LS3203 LS3204 0.3664
K3203002 LS3203 LS3205 0.02634
*
K3204001 LS3204 LS3205 0.3678
K3204002 LS3204 LS3206 0.0274
*
K3205001 LS3205 LS3206 0.3739
K3205002 LS3205 LS3207 0.02957
K3205003 LS3205 LS3208 0.01537
*
K3206001 LS3206 LS3207 0.3795
K3206002 LS3206 LS3208 0.0472
*
K3207001 LS3207 LS3208 0.4931
* Kqtsraqsse1
K8101001 LS8101 LS8102 0.2387
K8101002 LS8101 LS8103 0.03268
K8101024 LS8101 LS6301 0.02318
*
K8102001 LS8102 LS8103 0.2179
K8102002 LS8102 LS8104 0.02926
K8102023 LS8102 LS6301 0.01816
*
K8103001 LS8103 LS8104 0.2174
K8103002 LS8103 LS8105 0.02916
K8103022 LS8103 LS6301 0.01775
*
K8104001 LS8104 LS8105 0.2174
K8104002 LS8104 LS8106 0.02913
K8104021 LS8104 LS6301 0.01772
*
K8105001 LS8105 LS8106 0.2172
K8105002 LS8105 LS8107 0.02876
K8105020 LS8105 LS6301 0.01793
*
K8106001 LS8106 LS8107 0.2153
K8106002 LS8106 LS8108 0.02863
K8106019 LS8106 LS6301 0.01891
*
K8107001 LS8107 LS8108 0.2202
K8107018 LS8107 LS6301 0.02301
*
K8108017 LS8108 LS6301 0.04064
*
K4201001 LS4201 LS4202 0.2109
K4201002 LS4201 LS4203 0.02241
*
K4202001 LS4202 LS4203 0.1912
K4202002 LS4202 LS4204 0.0199
*
K4203001 LS4203 LS4204 0.1909
K4203002 LS4203 LS4205 0.0203
*
K4204001 LS4204 LS4205 0.194
K4204002 LS4204 LS4206 0.02295
*
K4205001 LS4205 LS4206 0.207
K4205002 LS4205 LS4207 0.02729
*
K4206001 LS4206 LS4207 0.2162
K4206002 LS4206 LS4208 0.03316
*
K4207001 LS4207 LS4208 0.2419
* Kqtsraqssf
K9101001 LS9101 LS9102 0.379
K9101002 LS9101 LS9103 0.08024
K9101003 LS9101 LS9104 0.03524
K9101004 LS9101 LS9105 0.01985
K9101005 LS9101 LS9106 0.01324
K9101007 LS9101 LS9108 0.01307
K9101008 LS9101 LS5201 0.06596
K9101009 LS9101 LS5202 0.01615
K9101017 LS9101 LS7301 0.09883
*
K9102001 LS9102 LS9103 0.3052
K9102002 LS9102 LS9104 0.05616
K9102003 LS9102 LS9105 0.02253
K9102007 LS9102 LS5201 0.01958
K9102016 LS9102 LS7301 0.07047
*
K9103001 LS9103 LS9104 0.3
K9103002 LS9103 LS9105 0.05379
K9103003 LS9103 LS9106 0.02114
K9103015 LS9103 LS7301 0.0681
*
K9104001 LS9104 LS9105 0.2979
K9104002 LS9104 LS9106 0.05277
K9104003 LS9104 LS9107 0.02142
K9104004 LS9104 LS9108 0.01568
K9104014 LS9104 LS7301 0.06163
*
K9105001 LS9105 LS9106 0.2945
K9105002 LS9105 LS9107 0.05264
K9105003 LS9105 LS9108 0.02746
K9105013 LS9105 LS7301 0.04805
*
K9106001 LS9106 LS9107 0.2912
K9106002 LS9106 LS9108 0.06109
K9106008 LS9106 LS5206 0.01354
K9106009 LS9106 LS5207 0.01345
K9106011 LS9106 LS7301 0.06003
*
K9107001 LS9107 LS9108 0.3194
K9107008 LS9107 LS5207 0.01312
K9107010 LS9107 LS7301 0.1251
*
K9108009 LS9108 LS7301 0.326
*
K5201001 LS5201 LS5202 0.3294
K5201002 LS5201 LS5203 0.0587
K5201003 LS5201 LS5204 0.02564
K5201004 LS5201 LS5205 0.0158
K5201007 LS5201 LS5208 0.01524
K5201009 LS5201 LS7301 0.1725
*
K5202001 LS5202 LS5203 0.2689
K5202002 LS5202 LS5204 0.0409
K5202003 LS5202 LS5205 0.01618
K5202008 LS5202 LS7301 0.1547
*
K5203001 LS5203 LS5204 0.2657
K5203002 LS5203 LS5205 0.04023
K5203003 LS5203 LS5206 0.01622
K5203007 LS5203 LS7301 0.1565
*
K5204001 LS5204 LS5205 0.2688
K5204002 LS5204 LS5206 0.04339
K5204003 LS5204 LS5207 0.01891
K5204004 LS5204 LS5208 0.01775
K5204006 LS5204 LS7301 0.1456
*
K5205001 LS5205 LS5206 0.281
K5205002 LS5205 LS5207 0.05112
K5205003 LS5205 LS5208 0.03314
K5205005 LS5205 LS7301 0.108
*
K5206001 LS5206 LS5207 0.2952
K5206002 LS5206 LS5208 0.07734
K5206004 LS5206 LS7301 0.05697
*
K5207001 LS5207 LS5208 0.3704
K5207002 LS5207 LS7301 0.0742
*
K5208001 LS5208 LS7301 0.1847
.ENDS QTSRAQSS
