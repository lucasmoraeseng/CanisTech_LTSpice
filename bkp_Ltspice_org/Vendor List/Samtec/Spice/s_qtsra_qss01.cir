* s_qtsra_qss01
***************************************************************************
*                            COPYRIGHT, SAMTEC                            *
*                     ALL INTERNATIONAL RIGHTS RESERVED                   *
***************************************************************************
*!!!!!!!!!!!!!!!!!!!!!!!!!!!!!!!!!!!!!!!!!!!!!!!!!!!!!!!!!!!!!!!!!!!!!!!!!!
*! Samtec makes no warranty or guarantee as to the suitability of its     !
*! products or models for any specific application. Models were developed !
*! using nominal values for physical dimensions and material properties,  !
*! and specific grounding and boundary conditions.                        !
*!                                                                        !
*! Actual in-circuit performance can vary significantly from simulated    !
*! results.  All parameters should be validated by the customer's own     !
*! technical experts.  By downloading a model, the user agrees to absolve !
*! Samtec from all liability related to the use or application of the     !
*! model or product.                                                      !
*!                                                                        !
*! Samtec reserves the right to change a model at any time without        !
*! further notice.                                                        !
*!!!!!!!!!!!!!!!!!!!!!!!!!!!!!!!!!!!!!!!!!!!!!!!!!!!!!!!!!!!!!!!!!!!!!!!!!!
*
* Connector: QTS-xxx-01-x-D-RA__QSS-xxx-01-x-D-A-xx
* Rev Date : 02/13/2003
* Status   : DEVELOPMENTAL
* Structure: single-line (end pin and internal pin represented)
* Rating   : 750ps Tr/Tf (10%-90%) or slower
*
***************************************************************************
**** README ************ CONNECTOR MODEL STRUCTURE ************ README ****
***************************************************************************
*
* MODEL BOUNDARIES:  Male connector standoff to female connector standoff
* (NO TERMINATIONS, DRIVING SOURCES, OR PARASITIC CAPACITANCES ARE INCLUDED)
*
* NODE SEQUENCE:  **Important Note** - This model is "homogenous";
*                 it is a "black box" representation of the mated connector
*                 (lumped element and transmission line parameters included)
*
* CONNECTOR-TO-MODEL CROSS REFERENCE
* Model subcircuit "end pin" maps to connector pin 01 or 02
* Model subcircuit "internal pin" maps to connector pin 03, 04, and so on
*
***************************** CONNECTOR MODEL *****************************
****************** RLC MODELS ********************
*
* OUTER ROW, INTERNAL PIN
***************IN*OUT*REF
.SUBCKT QTRQSOI 1  2   3
*************************
L4 1 4 1.74NH
C5 4 3 1.77PF
L5 4 2 1.74NH
.ENDS QTRQSOI
*************
*
* OUTER ROW, END PIN ****
***************IN*OUT*REF
.SUBCKT QTRQSOE 1  2   3
*************************
L4 1 4 2.51NH
C5 4 3 1.22PF
L5 4 2 1.51NH
.ENDS QTRQSOE
************
*
* INNER ROW, INTERNAL PIN
***************IN*OUT*REF
.SUBCKT QTRQSII 1  2   3
*************************
L4 1 4 1.55NH
C5 4 3 0.9PF
L5 4 2 1.55NH
.ENDS QTRQSII
*************
*
* INNER ROW, END PIN ****
***************IN*OUT*REF
.SUBCKT QTRQSIE 1  2   3
*************************
L4 1 4 2.1NH
C5 4 3 0.67PF
L5 4 2 2.1NH
.ENDS QTRQSIE
************
*
********** TRANSMISSION LINE MODELS **************
*
* OUTER ROW, INTERNAL PIN
****************IN*OUT*REF
.SUBCKT QTRQSOIL 1  2  3
************************
T4 1 3 2 3 Z0=44 TD=79PS
.ENDS QTRQSOIL
***************
*
* OUTER ROW, END PIN *****
****************IN*OUT*REF
.SUBCKT QTRQSOEL 1  2   3
************************
T4 1 3 2 3 Z0=64 TD=78PS
.ENDS QTRQSOEL
***************
*
* INNER ROW, INTERNAL PIN
****************IN*OUT*REF
.SUBCKT QTRQSIIL 1  2  3
************************
T4 1 3 2 3 Z0=59 TD=53PS
.ENDS QTRQSIIL
***************
*
* INNER ROW, END PIN *****
****************IN*OUT*REF
.SUBCKT QTRQSIEL 1  2   3
************************
T4 1 3 2 3 Z0=79 TD=52PS
.ENDS QTRQSIEL
***************
