* FILENAME:         NE68033.CIR
* NEC PART NUMBER:  NE68033
* LAST MODIFIED:    7/97
* BIAS CONDITIONS:  Vce=2.5V to 6V, Ic=0.3mA to 20mA
* FREQ RANGE:       0.05GHz to 3GHz
*
*                            CCBpkg
*                    .-------||--------.
*                    |          CCB    |
*                    |      .--||---.  |       COLLECTOR
* BASE               |      |        | |
*                    |      |   /----o-o-----o--Lcx--o
*            o--Lbx--o-LB---o--|Q1   |       |
*                    |      B   \   --       --
*                    |          |   -- CCE   -- CCEpkg
*                    --CBEpkg E o----'       |
*                    --         |            |
*                    |         LE            |
*                    `----------o------------'
*                               |
*                               Lex
*                               |
*                               o EMITTER
*
*       CCB    = 0.08pF          LB  = 0.65nH
*       CCE    = 0.08pF          LE  = 0.95nH
*       CCBpkg = 0.1pF           Lbx = 0.3nH
*       CCEpkg = 0.1pF           Lcx = 0.5nH
*       CBEpkg = 0.01pF          Lex = 0.3nH
*
*                   c b e
.SUBCKT NE68033/CEL 2 1 3
Q1  5 7 8 NE68000
CCB 7 5 0.08E-12
CCE 5 8 0.08E-12
LE  8 6 0.95E-9
LB  4 7 0.65E-9
CCBPKG 4 5 0.1E-12
CCEPKG 5 6 0.1E-12
CBEPKG 4 6 0.01E-12
LBX 1 4 0.3E-9
LCX 5 2 0.5E-9
LEX 6 3 0.3E-9
* Q1 model parameters are as follows:
.MODEL NE68000 NPN
+(IS=3.84e-16    BF=124.9         NF=1.05        VAF=11.9         IKF=0.027
+ ISE=1e-14      NE=2.17          BR=1           NR=1.05          VAR=0
+ IKR=0          ISC=0            NC=2           RE=0.6           RB=17.9
+ RBM=1.02       IRB=4.01e-4      RC=10.5        CJE=0.358e-12    VJE=0.71
+ MJE=0.5        CJC=0.162e-12    VJC=0.79       MJC=0.64         XCJC=0
+ CJS=0          VJS=0.75         MJS=0          FC=0.5           TF=8.7e-12
+ XTF=18         VTF=19.1         ITF=0.082      PTF=0            TR=0.635e-9
+ EG=1.11        XTB=0            XTI=3          KF=0             AF=1 )
*
* NOTE:  CEL develops models using the Libra simulator.
*        For this simulator, a value of 0 for VAR and IKR is
*        interpreted as infinity.
.ENDS
*$
