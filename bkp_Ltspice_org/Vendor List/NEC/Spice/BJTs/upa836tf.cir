* FILENAME:        UPA836TF.CIR
* NEC PART NUMBER: UPA836TF
* LAST MODIFIED:   10/98
* BIAS CONDITIONS: Vce=0.5V to 5V, Ic=1mA to 10mA
* FREQ RANGE:      0.1GHZ to 3GHZ
*
*  This model schematic is too complex to be put in this format.
*  Please contact CEL at (408)988-3500 for the schematic and
*  documentation or download the model from our website,
*  www.cel.com.
*
*                    c1 b1 e1 c2 b2 e2
.SUBCKT UPA836TF/CEL P1 P6 P2 P3 P4 P5
Q1      2 1  3 NE68500
Q2      5 4  6 NE68800
CCB1      2  1  0.1pF
C_E1B2    6  3  0.3pF
CCB2      4  5  0.15pF
CCE2      5  6  0.19pF
C_C2E2    5  7  0.07pF
C_C2B2    5  8  0.1pF
C_B1B2    7  9  0.05pF
C_C1B1    2  9  0.1pF
C_C1B2    2  7  0.07pF
CCE1      3  2  0.14pF
C_C1E1   10  2  0.05pF
LC_X1    P1  2  0.05nH
LE_X1    P2 10  0.05nH
LC_X2    P3  5  0.05nH
LE_X2     7 P5  0.05nH
LB_X2     8 P4  0.05nH
LB_X1     9 P6  0.05nH
LB1       1  9  0.45nH
LB2       4  8  0.2nH
LE2       6  7  0.75nH
LE1      10  3  0.75nH
C_E1C2    5 10  0.05pF
C_B2E2    7  8  0.05pF
.MODEL NE68500 NPN
+( IS=7e-16       BF=109          NF=1          VAF=15          IKF=0.19
+ ISE=7.9e-13     NE=2.19         BR=1          NR=1.08         VAR=12.4
+ IKR=0           ISC=0           NC=2          RE=1.3          RB=10
+ RBM=8.34        IRB=0.009       RC=10         CJE=0.4e-12     VJE=0.812
+ MJE=0.5         CJC=0.18e-12    VJC=0.75      MJC=0.34        XCJC=0
+ CJS=0           VJS=0.75        MJS=0         FC=0.5          TF=2e-12
+ XTF=5.2         VTF=4.58        ITF=0.011     PTF=0           TR=1e-9
+ EG=1.11         XTB=0           XTI=3         KF=0            AF=1 )
*
.MODEL NE68800 NPN
+(IS=3.80e-16  BF=135.7         NF=1         VAF=28         IKF=0.6
+ ISE=3.8e-15  NE=1.49          BR=12.3      NR=1.1         VAR=3.5
+ IKR=0.06     ISC=3.5e-16      NC=1.62      RE=0.4         RB=6.14
+ RBM=3.5      IRB=0.001        RC=4.2       CJE=0.796e-12  VJE=0.71
+ MJE=0.38     CJC=0.549e-12    VJC=0.65     MJC=0.48       XCJC=0.56
+ CJS=0        VJS=0.75         MJS=0        FC=0.75        TF=11e-12
+ XTF=0.36     VTF=0.65         ITF=0.61     PTF=50         TR=0.032e-9
+ EG=1.11      XTB=0            XTI=3        KF=1.5e-14     AF=1.22 )
*
* NOTE:  CEL develops models using the Libra simulator.
*        For this simulator, a value of 0 for
*        IKR is interpreted as infinity.
.ENDS
*$
