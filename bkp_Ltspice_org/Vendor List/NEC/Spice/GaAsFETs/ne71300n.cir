* FILENAME:        NE71300N.CIR
* NEC PART NUMBER: NE71300(N)
* LAST MODIFIED:   12/97
* BIAS CONDITIONS: Vds=2V to 4V,  Id=10mA to 30mA
* FREQ RANGE:      0.5GHz to 20GHZ
*
* Idss=45.6mA at Vgs=0V, Vds=3V
* Vp =-1.2V   at Vds=3V, Id=0.01mA
*
* TOM GaAsFET Model
*
*               ---o--Rdx--Ld---o
*               |  |             DRAIN
*GATE       I --   RDB
*  o---Lg---I Q1   |
*           I---   CBS
*               |__|
*               |
*               Rsx
*               |
*               Ls
*               |
*               o SOURCE
*
*       Lg=0.36nH       RDB=400 ohms
*       Ls=0.02nH       CBS=100pF
*       Ld=0.36nH               Rdx=2 ohms
*                       Rsx=2 ohms
*
*                    d g s
.SUBCKT NE71300N/CEL 2 1 3
Z1   7  4  8 NE71300N
RDB  7  9  400
CBS  9  8  100E-12
Rsx  8  6  2
Rdx  7  5  2
Lg   4  1  0.36E-9
Ld   2  5  0.36E-9
Ls   6  3  0.02E-9
.MODEL NE71300N NMF (LEVEL=3
+ VTO=-1.04     ALPHA=4.5        BETA=0.0409       GAMMA=0.082
+ Q=1.9         DELTA=0.42       VBI=1             IS=7.3e-12
+ N=1.2         TAU=6e-12        CDS=0.15e-12      CGS=0.5e-12
+ CGD=0.04e-12  VDELTA=0.2       FC=0.5            RG=6
+ RD=0          RS=0             KF=0              AF=1
+ XTI=3         EG=1.43          VTOTC=0           BETATCE=0)
.ENDS
*$
