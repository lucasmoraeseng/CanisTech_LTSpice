* FILENAME:        NE76184A.CIR
* NEC PART NUMBER: NE76184A
* LAST MODIFIED:   12/97
* BIAS CONDITIONS: Vds=1V to 3V,  Id=5mA to 30mA
* FREQ RANGE:      0.1GHz to 18GHZ
*
*  TOM GaAsFET Model
*
*      -----------------------C1----------------------------.
*      |                                                    | DRAIN
*      |                      -----o--Rdx---Ld--o--L2---R2--o---o
*      |                      |    |            |           |
* GATE |                  I --     RDB          |           |
* o----o--R1---L1--o-Lg---I Q1     |            |           |
*      |           |      I---     CBS          |           |
*      |           |          |____|            C4          C5
*     C2          C3          |                 |           |
*      |           |         Rsx                |           |
*      |           |          |                 |           |
*      |           |         L3                 |           |
*      |           |          |                 |           |
*      |           |         R3                 |           |
*      |           |          |                 |           |
*      o-----------o----------o-----------------o-----------'
*                             |
*                             o SOURCE
*
*    Lg=0.55nH     L1=0.28nH     R1=0.5 ohms     C1=0.001pF
*    Ld=0.27nH     L2=0.3nH      R2=0.2 ohms     C2=0.01pF
*    Rdx=6 ohms    L3=0.16nH     R3=0.2 ohms     C3=0.125pF
*    Rsx=4 ohms                                  C4=0.1pF
*    RDB=350 ohms                                C5=0.01pF
*    CBS=100pF
*                    d g s
.SUBCKT NE76184A/CEL 2 1 3
Z1  13 10 12 NE76100
RDB 13 14 350
CBS 14 12 100E-12
Rsx 12  9 4
Rdx 13 11 6
Lg  10  7 0.55E-9
Ld  11  8 0.27E-9
C3   7  3 0.125E-12
L3   9  6 0.16E-9
R3   6  3 0.2
C4   8  3 0.1E-12
L2   8  5 0.3E-12
R2   5  2 0.2
C5   2  3 0.01E-12
L1   4  7 0.28E-9
R1   1  4 0.5
C2   1  3 0.01E-12
C1   1  2 0.001E-12
.MODEL NE76100 NMF (LEVEL=3
+ VTO=-1.2      ALPHA=7          BETA=0.0803       GAMMA=0.04
+ Q=2.6         DELTA=0.5        VBI=1             IS=1e-14
+ N=1           TAU=5e-12        CDS=0.22e-12      CGS=0.85e-12
+ CGD=0.06e-12  VDELTA=0.2       FC=0.5            RG=6
+ RD=0          RS=0             KF=0              AF=1
+ XTI=3         EG=1.43          VTOTC=0           BETATCE=0)
.ENDS
*$
